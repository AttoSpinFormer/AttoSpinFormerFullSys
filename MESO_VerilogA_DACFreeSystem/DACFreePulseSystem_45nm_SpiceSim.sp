*Related Paper:	 AttoSpinFormer: An Energy-efficient Magneto Electric Spin Orbit Logic-based Compute-in-Memory Transformer Architecture
R2 N001 N003 20k
V2 N001 0 2.7
M1 N003 N008 0 0 NMOS l=45n w=720n
M2 N004 N003 0 0 NMOS l=45n w=45n
M3 N001 N003 N004 N001 PMOS l=45n w=90n
M4 N001 N003 N010 N001 PMOS l=45n w=15u
M5 N001 N004 N010 0 NMOS l=45n w=15u
M6 N006 N009 0 0 NMOS l=45n w=45n
M7 N005 N006 N012 0 NMOS l=45n w=90n
M8 N012 N007 0 0 NMOS l=45n w=90n
M9 N002 N009 N006 N002 PMOS l=45n w=90n
M10 N002 N006 N005 N002 PMOS l=45n w=90n
M11 N002 N007 N005 N002 PMOS l=45n w=90n
V1 N009 0 PULSE(0 1 0 10p 10p 100n 200n 4)
V3 N007 0 PULSE(0 1 0 10p 10p 300n 600n 2)
V4 N002 0 1
M12 N002 N005 N008 N002 PMOS l=45n w=90n
M13 N008 N005 0 0 NMOS l=45n w=45n
R1 N019 N022 20k
V5 N019 0 1
M14 N022 N029 0 0 NMOS l=45n w=720n
M15 N026 N022 0 0 NMOS l=45n w=2u
M16 N019 N022 N026 N019 PMOS l=45n w=4u
M17 N027 N009 N031 0 NMOS l=45n w=90n
M18 N031 N007 0 0 NMOS l=45n w=90n
M19 N017 N009 N027 N017 PMOS l=45n w=90n
M20 N017 N007 N027 N017 PMOS l=45n w=90n
V7 N017 0 1
M21 N017 N027 N029 N017 PMOS l=45n w=90n
M22 N029 N027 0 0 NMOS l=45n w=45n
V6 N014 0 2.7
V8 N028 0 -2.7
M23 N016 N021 N030 0 PMOS l=45n w=15u
M24 N016 N024 N030 N023 NMOS l=45n w=15u
M25 N021 N018 N023 N023 NMOS l=45n w=45n
M26 0 N018 N021 0 PMOS l=45n w=90n
R4 N025 N026 1k
R5 N020 N015 100k
R6 N025 0 2k
R7 N018 N020 200k
V9 N015 0 1
V11 N023 0 -2.7
M27 N024 N021 N016 N016 NMOS l=45n w=45n
M28 0 N021 N024 0 PMOS l=45n w=90n
V13 N016 0 -2.7
R3 N011 N010 2
R8 N011 N030 2
R9 N013 N011 16k
R10 N013 0 2
XU1 N025 N020 N014 N028 N018 level1 Avol=1Meg GBW=40Meg Vos=0 En=0 Enk=0 In=0 Ink=0 Rin=500Meg
.model NMOS NMOS
.model PMOS PMOS
.lib standard.mos
;tran 0 100n 0 10p
.tran 0 400n 0 1n
;tran 0 100n 0 10p
.lib UniversalOpAmp1.lib
.backanno
.end
